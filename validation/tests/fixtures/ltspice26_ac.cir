RC reader fixture: ac
.temp 25
.options tnom=25 plotwinsize=0 reltol=1e-6 abstol=1e-12 vntol=1e-9 chgtol=1e-16 trtol=1 method=trap gminsteps=0 srcsteps=0 numdgt=15
Vgen in 0 DC 0.1 AC 1
Rseries in output 1000
Cload output 0 1u
.ac dec 100 20 20000
.save V(in) V(output)
.end
